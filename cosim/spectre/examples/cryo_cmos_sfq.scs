// Cadence Spectre + JoSIM Co-Simulation Example 1:
// 4K Cryo-CMOS Clock/Data Drivers Coupled to a 2-Port JoSIM RSFQ D-Flip-Flop (DRO)
simulator lang=spectre
global 0

ahdl_include "libjosim_spectre_dpi.so" -cds_va_dpi
ahdl_include "josim_cosim_port.va"

opts options temp=4.2 tnom=4.2 gmin=1e-12

model nch_4k mos1 type=n vto=0.20 kp=650u gamma=0.08 phi=0.6 lambda=0.02 cbd=0.2f cbs=0.2f cgso=20p cgdo=20p
model pch_4k mos1 type=p vto=-0.20 kp=320u gamma=0.08 phi=0.6 lambda=0.02 cbd=0.2f cbs=0.2f cgso=20p cgdo=20p

Vdd (vdd 0) vsource dc=0.8

// Input DATA pulse (at t = 18..22 ps) and CLOCK readout pulse (at t = 44..48 ps)
Vdin (din_in 0) vsource type=pwl wave=[0 0.8 17p 0.8 18p 0.0 22p 0.0 23p 0.8 100p 0.8]
Vclk (clk_in 0) vsource type=pwl wave=[0 0.8 43p 0.8 44p 0.0 48p 0.0 49p 0.8 100p 0.8]

// Cryo-CMOS Inverter + Source-Follower Drivers into Superconducting SFQ Ports
Mp_d  (drv_d din_in vdd vdd) pch_4k w=12u l=120n
Mn_d  (drv_d din_in 0   0)   nch_4k w=6u  l=120n
Msf_d (vdd   drv_d  sf_d 0)  nch_4k w=18u l=120n
Ratt_d (sf_d sfq_set) resistor r=1800

Mp_c  (drv_c clk_in vdd vdd) pch_4k w=12u l=120n
Mn_c  (drv_c clk_in 0   0)   nch_4k w=6u  l=120n
Msf_c (vdd   drv_c  sf_c 0)  nch_4k w=18u l=120n
Ratt_c (sf_c sfq_ro)  resistor r=1800

// 2-Port JoSIM Superconducting RSFQ DFF Subsystem
Xsfq_dff (sfq_set 0 sfq_ro 0) josim_cosim_port_2p \
    netlist="sfq_dff.cir" port_nodes="n_set,n_ro" port_modes="0,0"

dcOp dc
tran1 tran stop=75p step=0.25p maxstep=0.25p errpreset=conservative
save drv_d drv_c sfq_set sfq_ro

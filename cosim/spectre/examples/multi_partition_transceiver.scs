// Cadence Spectre + JoSIM Co-Simulation Example 3:
// Multi-Partition Superconducting-Semiconducting Transceiver
// (2 Concurrent JoSIM Subsystems + Inter-Chip Pad Network + 2-Stage 4K Cryo-CMOS LNA)
simulator lang=spectre
global 0

ahdl_include "libjosim_spectre_dpi.so" -cds_va_dpi
ahdl_include "josim_cosim_port.va"

opts options temp=4.2 tnom=4.2 gmin=1e-12

model nch_4k mos1 type=n vto=0.20 kp=650u gamma=0.08 phi=0.6 lambda=0.02 cbd=0.2f cbs=0.2f cgso=20p cgdo=20p

// JoSIM Partition 1: 2-JJ SFQ Transmitter
X_sfq_tx (n2 0) josim_cosim_port_norton netlist="sfq_tx.cir" port_nodes="n2" port_modes="0"

// Spectre Inter-Chip Bond-Pad / Inductor Filter
Lp1 (n2 mid) inductor  l=2.1p
Cp  (mid 0)  capacitor c=4f
Rp  (mid 0)  resistor  r=150
Lp2 (mid n3) inductor  l=2.1p

// JoSIM Partition 2: 2-Port SFQ Receiver + Electrothermal nTron Driver
X_ntron_rx (n3 0 nd 0) josim_cosim_port_2p netlist="ntron_rx_2p.cir" port_nodes="n3,nch" port_modes="0,0"

// Spectre 4K Cryo-CMOS 2-Stage Common-Source + Source-Follower Readout LNA
Vdd    (vdd 0)    vsource   dc=1.0
Vbias1 (vbias1 0) vsource   dc=0.28
Cc1    (nd g1)    capacitor c=2.0p
Rbias1 (vbias1 g1) resistor r=4k
M_cs   (d1 g1 0 0) nch_4k   w=24u l=120n
Rd1    (vdd d1)   resistor  r=1.2k
Cload1 (d1 0)     capacitor c=0.5f

Vbias2 (vbias2 0) vsource   dc=0.55
Cc2    (d1 g2)    capacitor c=2.0p
Rbias2 (vbias2 g2) resistor r=6k
M_sf   (vdd g2 vout 0) nch_4k w=32u l=120n
Rsf    (vout 0)   resistor  r=800
Cload2 (vout 0)   capacitor c=1.0f

dcOp dc
tran1 tran stop=60p step=0.2p maxstep=0.2p errpreset=conservative
save n2 mid n3 nd d1 vout

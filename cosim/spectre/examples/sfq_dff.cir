* JoSIM 2-Port RSFQ D-Flip-Flop (DRO) Core for Cadence Spectre Co-Simulation
* Port 1 (n_set): Data input -> JTL (B_in) -> Storage Junction B_set + Inductance L_stor
* Port 2 (n_ro):  Readout clock -> JTL (B_clk) -> Readout Junction B_ro
.model jjmod jj(rtype=1, vg=2.8m, cap=0.07p, r0=160, rn=16, icrit=100u)

* Input JTL stage on Port 1 (n_set)
R_in_pad  n_set n1 2.0
Ib_in     0     n1 pwl(0 0 4p 75u)
B_in      n1    0  jjmod area=1.0
Rsh_in    n1    0  2.5
L_12      n1    n2 3.8p

* Quantizing storage loop (B_set -- L_stor -- B_ro)
Ib_set    0     n2 pwl(0 0 4p 78u)
B_set     n2    0  jjmod area=1.0
Rsh_set   n2    0  2.5
L_stor    n2    n3 14.0p
B_ro      n3    0  jjmod area=1.15
Rsh_ro    n3    0  2.2
Ib_ro     0     n3 pwl(0 0 4p 62u)

* Readout clock JTL stage on Port 2 (n_ro)
R_clk_pad n_ro  n4 2.0
Ib_clk    0     n4 pwl(0 0 4p 75u)
B_clk     n4    0  jjmod area=1.0
Rsh_clk   n4    0  2.5
L_clk_ro  n4    n3 3.5p

* Output load resistor
R_load    n3    0  4.0

.tran 0.1p 100p
.print P(B_IN) P(B_SET) P(B_RO) I(L_STOR) V(N3)
.end

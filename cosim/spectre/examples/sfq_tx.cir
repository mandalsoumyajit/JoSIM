* Partition 1: 2-JJ SFQ Transmitter in JoSIM (Coupled at node n2)
.model jjmod jj(rtype=1, vg=2.8m, cap=0.07p, r0=160, rn=16, icrit=100u)

Iin  0  n1 pwl(0 0 8p 0 9p 220u 11p 220u 12p 0)
Ib1  0  n1 pwl(0 0 4p 75u)
B1   n1 0  jjmod
Rsh1 n1 0  2.5
L12  n1 n2 4.2p
Ib2  0  n2 pwl(0 0 4p 75u)
B2   n2 0  jjmod
Rsh2 n2 0  2.5

.tran 0.1p 60p
.print P(B1) P(B2) V(N2)
.end

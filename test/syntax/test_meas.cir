* Test SPICE .meas / .measure engine with native SFQ event triggers & waveform reductions
.model jj1 jj(rtype=1, vg=2.8m, cap=0.07p, r0=160, rn=16, icrit=0.25m)

Vin 4 0 sfq(20p 25p 2p 101101)
L1  4 5 2p
B01 5 0 jj1 area=1.0
IB1 0 5 175u
L2  5 6 4p
B02 6 0 jj1 area=1.0
IB2 0 6 175u
L3  6 7 2p
RL  7 0 2.0

.tran 0.25p 180p

* 1. Native SFQ event propagation delay
.meas tran t_prop TRIG P(B01) SFQ=1 TARG P(B02) SFQ=1
* 2. Standard SPICE threshold crossing propagation delay
.meas tran t_val_prop TRIG P(B01) VAL=3.14159265 RISE=1 TARG P(B02) VAL=3.14159265 RISE=1
* 3. Event arrival time (WHEN ... SFQ=LAST)
.measure tran t_last WHEN P(B02) SFQ=LAST
* 4. Point and conditional lookups (FIND ... AT=..., FIND ... WHEN ...)
.meas tran phi_final FIND P(B02) AT=170p
.meas tran ib1_at_sw FIND I(IB1) WHEN P(B01) SFQ=1
* 5. Waveform window reductions (INTEG, AVG, RMS, MAX, PP)
.meas tran flux_p1 INTEG V(B01) FROM=15p TO=35p
.meas tran ib1_avg AVG I(IB1) FROM=10p TO=150p
.meas tran v_max_b02 MAX V(B02) FROM=15p TO=40p
.meas tran v_pp_b02 PP V(B02) FROM=15p TO=40p
* 6. Native SFQ event & pulse metric reductions (COUNT, FREQ, VPEAK, FWHM, AREA)
.meas tran n_pulses COUNT P(B02)
.meas tran f_avg FREQ P(B02)
.meas tran vpk_1 VPEAK P(B02) SFQ=1
.meas tran fwhm_1 FWHM P(B02) SFQ=1
.meas tran area_1 AREA P(B02) SFQ=1
* 7. Dependent parameter expressions (PARAM=...)
.meas tran delay_ps PARAM='t_prop * 1e12'
.meas tran flux_norm PARAM='flux_p1 / 2.067833848e-15'

.assert B02 count=4
.end

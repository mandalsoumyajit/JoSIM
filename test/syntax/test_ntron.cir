* Test Compact Superconducting Nanowire / Cryotron (nTron / hTron / SNSPD) Device (N)
.model NTRON_MOD ntron(ic=100u ig=20u ir=15u rn=500 l=40p lg=5p tau=15p tau_hs=2p)
.model SNSPD_MOD snspd(ic=50u ir=12u rn=800 l=50p tau=12p tau_hs=1.5p)
.model jjmod jj(rtype=1, vg=2.8m, cap=0.07p, r0=16, rn=16, icrit=0.1m)

* 1. 3-terminal nTron line driver / amplifier driving a 50-Ohm load
IB 0 drain PWL(0 0 10p 80u)
IG 0 gate  PWL(0 0 29p 0 31p 25u 40p 25u 42p 0)
N1 drain 0 gate NTRON_MOD
RL drain 0 50

* 2. 2-terminal nanowire / SNSPD overcurrent switching & self-reset with 50-Ohm shunt
IS2 0 n2 PWL(0 0 10p 40u 60p 40u 62p 60u 70p 60u 72p 40u)
N2 n2 0 SNSPD_MOD
RSH2 n2 0 50

* 3. 4-terminal cryotron inside a subcircuit triggering an overdamped RSFQ Josephson junction
.subckt CRYO_DRV d s gp gm IC_CH=120u IG_CH=20u
NDRV d s gp gm NTRON_MOD IC={IC_CH} IG={IG_CH} IR=25u RN=400 L=25p LG=6p RG=2 TAU=8p
.ends CRYO_DRV

IB3 0 d3 PWL(0 0 10p 100u)
IG3 0 gp3 PWL(0 0 49p 0 50p 30u 53p 30u 54p 0)
XDRV d3 0 gp3 0 CRYO_DRV IC_CH=120u IG_CH=20u
RL3 d3 0 50
RCOUP d3 jnode 60
LCOUP jnode bnode 8p
IBJ 0 bnode PWL(0 0 10p 75u)
B1 bnode 0 jjmod
RSHB1 bnode 0 2.5

.tran 0.25p 160p

.print DEVV N1
.print DEVI N1
.print I(N1|G)
.print NODEV n2 0
.print DEVI N2
.print DEVV B1
.print PHASE B1

.meas tran V1_PRE   MAX V(N1) FROM=15p TO=28p
.meas tran V1_PEAK  MAX V(N1) FROM=30p TO=70p
.meas tran ICH_MIN  MIN I(N1) FROM=32p TO=60p
.meas tran IG1_PEAK MAX I(N1|G) FROM=30p TO=45p
.meas tran V1_FINAL MAX V(N1) FROM=140p TO=158p
.meas tran ICH_FIN  MIN I(N1) FROM=140p TO=158p
.meas tran V2_PEAK  MAX V(n2) FROM=60p TO=100p
.meas tran IN2_MIN  MIN I(N2) FROM=62p TO=90p
.meas tran IN2_FIN  MIN I(N2) FROM=140p TO=158p
.meas tran V3_PEAK  MAX V(d3) FROM=48p TO=100p
.meas tran V3_FIN   MAX V(d3) FROM=140p TO=158p
.meas tran IB1_MAX  MAX I(B1) FROM=48p TO=100p
.meas tran IB1_FIN  MAX I(B1) FROM=140p TO=158p
.meas tran P_B1_FIN MAX P(B1) FROM=140p TO=158p
.meas tran T_B1_SW  TRIG V(d3) VAL=1.0m RISE=1 TARG P(B1) PULSE=1

.assert B1 COUNT=1

.end

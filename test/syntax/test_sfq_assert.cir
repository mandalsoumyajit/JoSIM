* Test native SFQ() quantized pulse-train source and .assert directives
B01        3          7          jmitll     area=2.16
B02        6          8          jmitll     area=2.16
IB01       0          1          pwl(0      0 5p 280u)
L01        4          3          2p
L02        3          2          2.425p
L03        2          6          2.425p
L04        6          5          2.031p
LP01       0          7          0.086p
LP02       0          8          0.096p
LPR01      2          1          0.278p
LRB01      7          9          0.086p
LRB02      8          10         0.086p
RB01       9          3          5.23
RB02       10         6          5.23
ROUT       5          0          2
VIN        4          0          sfq(20p 25p 2p 101101)
.model jmitll jj(rtype=1, vg=2.8mV, cap=0.07pF, r0=160, rN=16, icrit=0.1mA)
.tran 0.25p 200p 0 0.25p
.assert B01 td=20p per=25p bits=101101
.assert B02 td=20p per=25p bits=101101
.assert B02 count=4
.assert B02 times=24.65p,74.65p,99.65p,149.65p tol=0.5p
.assert B02 after B01 delay=1.83p tol=0.5p
.end
